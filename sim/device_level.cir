* Device-level discrete model -- analog 4-20 mA NTC transmitter
* Real BJT models (2N3904/3906-class, BCP56-class power NPN) + behavioral
* macromodels for the ICs (OPA333 single-pole RR, LM4040 & TL431 shunt refs).
* Uses the CONSOLIDATED resistor values and R16 = 49.9 ohm.
*
* Validates what the ideal netlist could not: the discrete pre-regulator,
* the Q4/Q5 constant-current bias source, the excitation current sink, and the
* OUTPUT SERVO (emitter-sense -> the ~2.6 mA quiescent is absorbed by ZERO).
*
* Loop current = TOTAL current into the instrument = I(VAM).

.param R25=10000 BETA=3892
.param VLOOP=24 RREC=250

* ---- loop supply, receiver load, reverse-polarity diode, ammeter ----
Vloop SUP 0 {VLOOP}
Rrec  SUP LOOPP {RREC}
D1    LOOPP DK DSS14
VAM   DK IN 0

* ---- temperature carried as a node voltage: 1 V = 1 degC ----
Vtemp temp 0 30

* ===================== PRE-REGULATOR (VL = 5 V) =====================
Q1 IN NBIAS VL QN3904
XU2 NBIAS 0 FB TL431
R3 VL FB 10k
R4 FB 0 10k
R5 NBIAS VL 100k
C2 VL 0 1u
* Q4/Q5 high-side constant-current bias source (~1.5 mA)
Q4 NBIAS BASE4 E4 QP3906
Q5 BASE4 E4 IN QP3906
R17 IN E4 432
R18 BASE4 0 100k

* ===================== REFERENCE (2.5 V) =====================
XU1 VREF 0 LM4040
R2 VL VREF 2.49k
C7 VREF 0 100n

* ===================== EXCITATION (0.25 mA current sink) =============
XA1 VSP SENSE A1OUT VL 0 OPA333
Q3 X A1OUT SENSE QN3904
R6 VREF VSP 10k
R7 VSP 0 2.49k
R8 SENSE 0 2k
C3 A1OUT 0 100p
Rntc VREF X r='R25*exp(BETA*(1/(v(temp)+273.15)-1/298.15))'
R1 VREF X 6.04k

* ===================== GAIN / ZERO AMP =====================
XA2 VXP VNEG VCMD VL 0 OPA333
R9  X VXP 100k
R12 VXP 0 249k
R10 VZERO VNEG 100k
R11 VNEG SPANW 249k
Rspan SPANW VCMD 8.4k
C4 VCMD VNEG 1n
* zero network (VREF - R13 - RV2 - R14 - GND); wiper = VZERO, set ~top
R13 VREF ZT 10k
Rztop ZT VZERO 0.62k
Rzbot VZERO ZB 4.38k
R14 ZB 0 10k
C5 VZERO 0 100n

* ===================== OUTPUT SERVO (emitter sense) =====================
XA3 VCMD ISENSE A3OUT VL 0 OPA333
Q2 IN QBASE ISENSE QBCP56
R15 A3OUT QBASE 2.49k
R16 ISENSE 0 49.9
C6 A3OUT ISENSE 10n

* ============================ MODELS ============================
.model DSS14 D(IS=2u RS=0.02 N=1.0 BV=40)
.model QN3904 NPN(IS=6.7f BF=300 VAF=74 IKF=0.06 ISE=6.7f NE=1.5 BR=4 RB=10 RC=1 CJE=4.5p CJC=3.6p TF=0.3n TR=240n)
.model QP3906 PNP(IS=1.4f BF=180 VAF=18 IKF=0.08 RB=10 RC=2.5 CJE=4.5p CJC=3.6p TF=0.5n TR=34n)
.model QBCP56 NPN(IS=1e-13 BF=160 VAF=100 IKF=0.5 RB=2 RC=0.3 RE=0.05 CJE=200p CJC=40p TF=20n TR=1u)

.subckt OPA333 inp inn out vcc vee
* gm stage into high-Z node, diode-clamped to the rails, unity buffer out
Gm 0 nb VALUE={5e-5*(V(inp)-V(inn))}
Rb nb 0 1e9
Cb nb 0 1u
Dh nb vcc DCLP
Dl vee nb DCLP
Eb obuf 0 nb 0 1
Rob obuf out 75
.ends
.model DCLP D(IS=1e-10 N=0.05 RS=1)

.subckt LM4040 K A
Bsh K A I={max(0,1e3*(V(K)-V(A)-2.5))}
Rl K A 1e8
.ends

.subckt TL431 K A REF
Bsh K A I={max(0,1e3*(V(REF)-V(A)-2.5))}
Rr REF A 1e8
.ends

.options gmin=1e-11 abstol=1e-10 reltol=2e-3 itl1=300
.control
dc Vtemp 18 42 1
let iloop_mA = i(VAM)*1000
print v(temp) v(VL) v(VREF) v(x) v(vcmd) iloop_mA
.endc
.end
